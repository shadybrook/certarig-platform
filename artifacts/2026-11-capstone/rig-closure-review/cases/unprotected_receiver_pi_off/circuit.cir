CertaRig stocked-product loop envelope: unprotected_receiver_pi_off
* Bounded equivalents, not a SEN0262 or MAX14626 vendor macromodel.
* 120ohm cases examine the SEN0262 burden INPUT, not its TP5551 output.
Vloop loop 0 24
Btx loop raw I=min(min(0.02,0.033),max(0,(v(loop)-v(raw)-11)/55))
Rburden raw 0 120
Vrail rail 0 PWL(0 3.3 .01 3.3 .010001 0 .04 0)
Rdirect raw pin 100
Cpin pin 0 10p

Radc pin 0 6Meg
Dhi pin rail ESD
Dlo 0 pin ESD
.model ESD D(Is=1p N=1.3 Rs=10 Cjo=4p)
Bhead head 0 V=v(loop)-v(raw)-11-abs(i(Vloop))*55
Bpower power 0 V=v(raw)*v(raw)/120

.options method=gear reltol=1e-5
.control
set wr_singlescale
set wr_vecnames
set numdgt=12
tran 2e-06 0.04 0 2e-06
wrdata trace.dat v(raw) v(pin) v(rail) v(head) v(power) i(Vrail) i(Vloop)
quit
.endc
.end
