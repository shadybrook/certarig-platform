CertaRig negative_receiver_12V_150R: sensor loop / ADC protection UNPROTECTED
Vloop loop 0 12
Bsensor loop raw I=min(0.02,max(0,(v(loop)-v(raw)-10)/1))
Rburden raw 0 150
Vrail rail 0 3.3
Vinst inst 0 5
Rinput raw pin 1
Cinput pin 0 100n
Radc pin 0 6Meg
Dadc_hi pin rail ESD
Dadc_lo 0 pin ESD
.model ESD D(Is=1p N=1.3 Rs=10 Cjo=4p)
Bheadroom headroom 0 V=v(loop)-v(raw)-10-abs(i(Vloop))*0
Bburden_power power 0 V=v(raw)*v(raw)/150
.options method=gear reltol=1e-5
.control
set wr_singlescale
set wr_vecnames
set numdgt=12
tran .000002 .04 0 .000002
wrdata trace.dat v(raw) v(pin) v(rail) v(headroom) v(power) i(Vrail) i(Vloop)
quit
.endc
.end
